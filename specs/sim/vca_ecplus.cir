* POGO VCA Ec+ unity trim — HIGH-3, change 0020 block-4/block-6 DRIVE
* THAT2180 Ec+ is a high-impedance control port (~6.1 mV/dB). The current netlist wires
* the "unity trim" as a 2-terminal SERIES RHEOSTAT between V_CTRL and Ec+. Because Ec+
* draws ~µA, a series R produces a negligible drop -> it CANNOT set the unity (0 dB)
* offset. The fix is a VOLTAGE-INJECTION trim: a trimmer across a small ±ref whose wiper
* feeds Ec+ through a series R, adding an adjustable mV offset.
*
* We model the Ec+ port as a high-Z node (a large R to GND ~ the port's input R) plus a
* tiny bias current, and compare the Ec+ voltage achievable by each topology over the
* full trim travel. Unity needs Ec+ trimmable through 0 with ~±a-few-mV authority
* (a few dB of unity-gain error correction at 6.1 mV/dB).

.param Rport=10meg     ; THAT2180 Ec+ effective input resistance (high-Z)
.param Ibias=50n       ; representative Ec+ port bias current
.param Vctrl=0.0       ; control node nominal (unity target = 0V at Ec+)

* ---------- (a) BUGGY: series rheostat from V_CTRL to Ec+ ----------
* sweep the rheostat 0..500 ohm (3224W 500R part); read Ec+.
Vc a_ctrl 0 DC {Vctrl}
Rrheo a_ctrl ecp_a {RR}
Rport_a ecp_a 0 {Rport}
Ibias_a ecp_a 0 DC {Ibias}    ; port draws bias current
.param RR=250

* ---------- (b) FIXED: voltage-injection divider ----------
* CORRECTED design (SPICE showed ±0.1V was ±17dB = far too coarse for a UNITY trim):
* bound the injection wiper to ~±12mV (e.g. ±12V rails through ~1M into a ~10k trim, i.e.
* a ~100:1 pre-divider) -> ±2 dB authority centered on 0 dB. wiper -> 100k -> Ec+ node.
Vw   b_w 0 DC {VW}
Rinj b_w ecp_b 100k
Rport_b ecp_b 0 {Rport}
Ibias_b ecp_b 0 DC {Ibias}
.param VW=0.0

.control
  echo "=== (a) BUGGY series rheostat: Ec+ vs rheostat value (Vctrl=0) ==="
  foreach r 0 250 500
    alterparam RR = $r
    reset
    op
    echo "  Rrheo=$r ohm -> Ec+ = " $&v(ecp_a) " V  (essentially -Ibias*Rport; rheostat does ~nothing)"
  end
  echo "=== (b) FIXED injection divider (corrected ±12mV wiper -> ±2dB): Ec+ vs wiper ==="
  foreach w -0.0122 -0.006 0 0.006 0.0122
    alterparam VW = $w
    reset
    op
    let db = v(ecp_b)/0.0061
    echo "  Vw=$w V -> Ec+ = " $&v(ecp_b) " V  (~" $&db " dB at 6.1mV/dB)"
  end
  echo "Unity (0 dB) needs Ec+ trimmable through 0 with ~few-mV authority: (b) gives ~±2dB centered;"
  echo "(a) series rheostat moves Ec+ only ~25uV (0.004dB) across full travel -> does nothing."
.endc
.end
