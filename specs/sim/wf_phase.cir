* POGO WF-vs-SC phase check — H4 verification (change 0020 §F)
* Question: does the wavefold (WF) cell have the SAME small-signal sign as soft-clip (SC)
* from the common BP1_DRIVEOUT node? If yes, H4 (WF phase-inverted) is FALSE and we must
* NOT add an inversion. The leading DRIVE-VCA inversion is common to all 3 cells, so only
* the RELATIVE cell sign matters here. Ideal op-amps (B-sources); diodes modeled as ideal
* clamp at +-1.4V so we see both the linear region and the fold.

Vd din 0 DC 0     ; common drive node (swept)

* ---- SC cell: inverting gain -1 (diodes off in linear region) ----
* Vsc = -din  (R18=R19=10k)
Bsc sc 0 V = -1 * V(din)

* ---- WF cell ----
* stage1 inverting: Vfoldin = -din
Bfold foldin 0 V = -1 * V(din)
* clamp node: Vclamp = Vfoldin clamped to +-1.4V (2x1N4148 each polarity)
Bclamp clamp 0 V = (V(foldin) >  1.4) ?  1.4 : ( (V(foldin) < -1.4) ? -1.4 : V(foldin) )
* folder stage2: Vout = 2*Vclamp - Vfoldin
Bwf wf 0 V = 2*V(clamp) - V(foldin)

.control
  dc Vd -3 3 0.25
  * print SC and WF vs input; check sign of both near 0 and the fold above 1.4
  print v(sc) v(wf)
  * small-signal slopes around 0:
  let i0 = length(v(din))/2
  echo "=== small-signal sign check (near din=0) ==="
  meas dc sc_lo find v(sc) at=-0.5
  meas dc sc_hi find v(sc) at=0.5
  meas dc wf_lo find v(wf) at=-0.5
  meas dc wf_hi find v(wf) at=0.5
  echo "SC slope sign = sign(sc_hi - sc_lo); WF slope sign = sign(wf_hi - wf_lo)"
  echo "If both negative (out falls as din rises), SC and WF AGREE -> H4 false."
.endc
.end
