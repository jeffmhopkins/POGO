* POGO mod-bus §H — raise destination impedance to cut buffer load (change 0020)
* Scale the attenuverter network x5: R_INV_IN/FB 10k->47k, pot 10k->50k (keeps the -1
* inverter gain and the +-1 attenuverter ratio; only impedance changes). Re-check the
* per-destination load + the 18-dest total the distribution buffer must drive.
* Inverter modeled as an ideal op-amp (high-gain VCVS) so invn is a real virtual ground
* and nvsrc = -V_src (matching the validated modbus_load.cir reconciliation).

.param RIN=47k       ; new R_INV_IN (= R_INV_FB)
.param RPOT=50k      ; new attenuverter pot

Vbus bus 0 DC 10
Rprot bus vsrc 100
Rinv  vsrc invn {RIN}        ; R_INV_IN -> inverter (-) virtual ground
Rfb   invn nvsrc {RIN}       ; R_INV_FB closes the -1 inverter
Eop   nvsrc 0 0 invn 1e6     ; ideal op-amp: (+)=GND, (-)=invn -> nvsrc; drives invn to 0
Rpot  vsrc nvsrc {RPOT}      ; attenuverter pot end-to-end (V_src to -V_src)

.control
  op
  let isrc = (10 - v(vsrc))/100
  let itot = isrc*18
  echo "RIN=47k, RPOT=50k (x5):"
  print v(vsrc) isrc itot
  echo "  -> itot is the buffer worst-case (all 18 at +10V). Target << 20mA."
.endc
.end
