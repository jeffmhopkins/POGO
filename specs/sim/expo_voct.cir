* POGO expo converter — V/oct base-divider validation (change 0020 §A)
* CORRECTED topology (SPICE caught the original 2.1x error 2026-05-30):
* the +4110ppm tempco (Vishay TFPT 1k) IS the shunt leg to GND (so the whole
* shunt tracks temperature); the SERIES leg sets the ~17.92 mV/oct ratio.
*
*   V_freq --[R_VOCT 51.1k]--[RV_1VOCT 0..10k wiper]--+-- Q1 base (node b)
*                                                     |
*                                          [R_TEMPCO 1k TFPT] --> GND
*
* Target base ratio = V_T*ln2 = 17.92 mV per input volt (= 1 V/oct -> 1 octave).
* Validates DIVIDER RATIO + TRIM AUTHORITY (resistive DC). Tempco SLOPE
* (+4110 vs ideal ~+3413 ppm/K) over-compensates ~20% — trim sets room-temp
* setpoint only; residual tempco-slope error noted as a known limit.

Vfreq in 0 DC 1
Rvoct  in a 51100
Rwiper a  b {RWIP}
Rtempco b 0 1000

.param RWIP=5000

.control
  foreach w 0 5000 10000
    alterparam RWIP = $w
    reset
    op
    let mvpv = v(b)*1000
    echo "RV_1VOCT = $w ohm  ->  base = " $&mvpv " mV per input volt"
  end
  echo "target = 17.92 mV/oct (V_T*ln2). In-band if ~16..20 across the sweep."
.endc
.end
