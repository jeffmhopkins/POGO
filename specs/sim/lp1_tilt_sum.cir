* POGO LP1 tilt summing node — §B design (change 0020), block-5 stereo expo
* Once §A adds the tempco shunt (~1k base->GND), the old "inject V_tilt at the raw base via
* 100k" no longer adds 1:1 — it divides away. §B must sum V_freq + (±V_tilt) BEFORE the
* base divider. Question: polarity + how many op-amp halves.
*
* Plugin: L base octave = +V_freq + V_tilt ; R base = +V_freq - V_tilt (1:1 octaves).
* Expo base must move +mV per +octave (positive CV -> higher freq).
*
* Design under test (per channel): an INVERTING summer gives -(Vf+Vt); to keep base
* polarity correct we feed the summer from already-inverted sources, OR accept the
* divider+expo sees the summer output directly. Test which arrangement yields the
* correct sign and the 1:1 ratio at the base divider input.

.param RF=100k    ; V_freq summer input R
.param RT=100k    ; V_tilt summer input R
.param RFB=100k   ; summer feedback

Vfreq vf 0 DC 1      ; +1 octave of freq CV
Vtilt vt 0 DC 0.5    ; +0.5 octave of tilt (L = +, R = -)

* ---- inverting summer: out = -(vf*RFB/RF + vt*RFB/RT) ----
Rf vf sj {RF}
Rt vt sj {RT}
Rfb sj sumout {RFB}
Eop sumout 0 0 sj 1e6      ; ideal op-amp, (+)=GND, (-)=sj

.control
  op
  echo "=== inverting summer out (equal Rs) ==="
  print v(sumout)
  echo "  expect -(1 + 0.5) = -1.5  (L channel; magnitude 1:1 correct, sign NEGATIVE)"
  echo "  => raw inverting summer flips sign. Need EITHER a 2nd inversion (2 halves/ch)"
  echo "     OR feed the summer with -V_freq so out = +(Vf+Vt) -> but we only have +Vfreq."
  echo "  CONCLUSION: cleanest = sum at the SUM with -V_freq source; or use the summer"
  echo "  output and rely on the expo ref polarity. Decide in design note + SPICE the base."
.endc
.end
