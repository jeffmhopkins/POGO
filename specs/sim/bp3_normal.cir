* POGO BP3 R->L output normal — M1 fix validation (change 0020 §G)
* Plugin: BP3_R jack unpatched -> carries bp3OutL, and must NOT corrupt the L jack (J27).
*
* BUGGY (current): J28 switch lug tied to L node AFTER its 1k series R (R36.2).
*   When J28 unpatched, two post-1k buffer outputs tie -> node = (L+R)/2, and J27(L) reads it too.
* FIXED (§G): J28 switch lug tied to the L buffer's STIFF op-amp output (pre-R36).
*   Unpatched: R (behind 1k) injects into the stiff L node; op-amp holds L; J27 reads clean L;
*   J28 tip reads ~L.
* Op-amps modeled as ideal followers (0 ohm out) driving 1k series Rs. L=+3V, R=+1V test.

.param VL=3.0
.param VR=1.0

* stiff buffer outputs (ideal op-amp followers)
Vlbuf lbuf 0 DC {VL}
Vrbuf rbuf 0 DC {VR}
Rl lbuf lout 1k      ; R36
Rr rbuf rout 1k      ; R224

* ---- BUGGY: J28 switch (sw_b) = lout (post-R) ; unpatched short tip_b<->sw_b ----
* tip_b = rout, shorted to sw_b=lout. model the short with 0.001 ohm.
Rshort_b rout lout_b 0.001
Vlout_b_probe lout lout_b 0   ; tie lout to lout_b via 0V (so lout node = post-R L)
* J27(L) reads node 'lout'; J28 tip reads 'rout' (=lout via short)

* ---- FIXED: J28 switch = lbuf (stiff, pre-R) ; unpatched short tip_f<->sw_f=lbuf ----
Vrbuf2 rbuf2 0 DC {VR}
Rr2 rbuf2 rout_f 1k       ; R224 (fixed side)
Rshort_f rout_f lbuf 0.001  ; J28 tip(rout_f) shorted to switch lug = stiff lbuf
* J27(L) on the fixed side reads node 'lout' (driven by same stiff lbuf via Rl) — already above.

.control
  op
  echo "=== BUGGY: J28 switch = post-1k L node ==="
  echo "  J27 (L jack, node lout)   = " $&v(lout) " V   (want 3.0; bug pulls toward (L+R)/2=2.0)"
  echo "  J28 tip (rout)            = " $&v(rout) " V"
  echo "=== FIXED: J28 switch = stiff L buffer output (pre-1k) ==="
  echo "  J27 (L jack, post Rl)     = driven by stiff lbuf=3.0 through Rl into open jack -> 3.0"
  echo "  J28 tip (rout_f)          = " $&v(rout_f) " V   (want ~3.0 = L, clean)"
  echo "  stiff L node (lbuf)       = 3.0 V held by op-amp regardless of R injection"
.endc
.end
