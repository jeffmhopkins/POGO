* POGO Q-cell Iabc bias — M5 (bias math) + H6 (range/trim authority), change 0020 §D
* The LM13700 amplifier-bias (Iabc) pin sits ~2*Vbe above V- (≈ -10.8V at -12V), NOT
* ground. So Iabc = (V_ires - V_pin)/R_Iabc. The spec assumed V_pin=0 (the M5 bug).
* Iabc is just the resistor current; no LM13700 model needed.
* Q relation: Q = 52mV/(Iabc*R_in), R_in = 100k.

.param Vpin=-10.8

* (a) BUGGY: R_Iabc=1M from ~0V control node
Vires_bug nbug 0 DC 0.0
Rbug nbug pin_b 1e6
Vpinb pin_b 0 DC {Vpin}

* (b) FIXED: R_Iabc=100k from a negative V_ires near the pin
Vires_fix nfix 0 DC -10.73
Rfix nfix pin_f 100k
Vpinf pin_f 0 DC {Vpin}

.control
  op
  echo "=== (a) buggy 1M @ Vires=0 ==="
  let ib = i(Vpinb)
  echo "Iabc(buggy) = " $&ib " A  (spec claimed 0.74uA -> ~14x off; Q pinned at min)"

  echo "=== (b) fixed 100k: trim sweep V_ires -> Iabc -> Q (R_in=100k) ==="
  foreach v -10.0 -10.4 -10.6 -10.73 -10.78 -10.795
    alter Vires_fix dc = $v
    op
    let iabc = i(Vpinf)
    let q = 0.052/(iabc*1e5)
    echo "  Vires=$v V   Iabc=" $&iabc " A   Q=" $&q
  end
  echo "Target: Q~0.7 (Butterworth floor) reachable; controlled Q up to ~10-50;"
  echo "self-osc (Q>>) via soft-limit diodes, not Iabc precision (H6)."
.endc
.end
