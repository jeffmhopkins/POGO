* POGO LP1 §B — passive sum-at-base vs op-amp summer (change 0020, block-5)
* Idea: feed V_freq AND ±V_tilt into the expo base through SEPARATE equal series resistors,
* with the §A tempco shunt (1k) base->GND. They passively sum with equal weight and the
* same ~18mV/oct scaling -> no op-amp summer (+1 TL072) needed, IF the ratios work.
*
* L base: V_freq via R_VOCT_a(49.9k)+RV(wiper) ; +V_tilt via R_TILT(49.9k) ; tempco 1k -> GND.
* Test the base mV per octave for freq-only, tilt-only, and combined.

.param RVOCT=49900
.param RV=5000       ; 1V/oct wiper mid
.param RTILT=49900   ; tilt series R = R_VOCT (1:1 octave sum)
.param RSH=1000      ; tempco shunt

Vfreq vf 0 DC 0
Vtilt vt 0 DC 0
Rvoct vf a {RVOCT}
Rwip  a base {RV}
Rtilt vt base {RTILT}
Rsh   base 0 {RSH}

.control
  * freq-only: 1V freq, 0 tilt
  alter Vfreq dc=1
  alter Vtilt dc=0
  op
  let bf = v(base)*1000
  * tilt-only: 0 freq, 1V tilt
  alter Vfreq dc=0
  alter Vtilt dc=1
  op
  let bt = v(base)*1000
  * combined: 1V freq + 0.5V tilt (L = +)
  alter Vfreq dc=1
  alter Vtilt dc=0.5
  op
  let bc = v(base)*1000
  print bf bt bc
  echo "bf=freq-only mV/V, bt=tilt-only mV/V, bc=combined(1+0.5)."
  echo "Want bf~17.9, bt~17.9 (1:1 octave weight), bc~bf+0.5*bt (~26.8). Tempco loads both."
.endc
.end
