* aux/filter/voct-expo-divider — base divider slope = V_T*ln2 = 17.92 mV/oct (LIBRARY primitive)
* Generic representative values (NO netlist_bind by design — there is no netlist behind a
* library primitive). This primitive IS the passive divider that scales 1 V/oct CV down to the
* base voltage the expo transistor needs. A BJT doubles I_c per V_T*ln2 of base drive, so to map
* 1 V/oct (DSP f0 = f_ref*2^Vctrl, LPFilter.hpp:20 / HPFilter.hpp:18) onto the base the divider
* must deliver V_T*ln2 = 25.85mV*0.69315 = 17.92 mV per input volt at 25 C.
*
* Divider: series R_VOCT into the base node, shunt R_T to GND. Slope = R_T/(R_VOCT+R_T).
* Pick a clean shunt R_T = 1k; then R_VOCT+R_T = 1000/0.01792 = 55804 -> R_VOCT = 54804.
* (POGO realizes R_VOCT ~ 49.9k fixed + ~4.9k trim at mid-travel; here we use the exact ratio.)
* The slope is set by the divider RATIO, computed from the spec target (V_T*ln2), NOT pinned by
* the deck: change either R and the measured mV/oct moves -> non-vacuous.
* Ideal model: a resistor divider driven by 1 V — this IS the base divider; no active device
* needed to check the divider ratio that sets mV/oct.

Vctrl vin 0 DC 1
Rseries vin nbase 54804     ; R_VOCT_total (series leg)
Rshunt  nbase 0 1000        ; R_T (shunt leg to GND)

.control
  op
  let mv_per_oct = v(nbase)*1000     ; volts at base per 1 V input, in mV (= mV/oct)
  print mv_per_oct
.endc
.end
