* aux/modulation/attenuverter — -V_att UNITY inverter (R_inv_f/R_inv_in = -1) (LIBRARY generic)
* LIBRARY CHECK (generic hardcoded representative values; NO netlist_bind by design, per
* specs/aux/_LIBRARY.md "Library sim convention").
*
* CLAIM (spec.md "Pot Wiper Between +V and -V" lines 82-88, "Center Detent" 90-97):
*   The negative pot rail -V_att is generated by an inverting unity-gain op-amp half:
*     -V_att = -(R_inv_f/R_inv_in)*V_att, with R_inv_f = R_inv_in -> gain = -1.
*   This exact -1 is what makes the center (theta=0) wiper read 0 (spec lines 94-97) and gives the
*   bipolar attenuverter span att in [-1,+1] (the analog of applyDestination=source*att,
*   ModBus.hpp:32). A mismatch R_inv_f != R_inv_in skews center-null and the +-1 endpoints.
*
* REPRESENTATIVE VALUES (generic library; spec's matched pair, here 10k/10k per the spec
*   Component Values table): R_inv_in = 10k, R_inv_f = 10k -> gain = -(10k/10k) = -1.0.
*   The ratio (not the absolute value) is the law; this catches single-ref drift (one resistor
*   left mismatched) but not a coordinated change of BOTH (the ratio survives).
*
* IDEAL MODEL (justification): Eop (1e6 VCVS) stands in for the TL074 section; the closed-loop
*   gain of an inverting amp is set entirely by R_inv_f/R_inv_in (virtual ground at (-)), which IS
*   the law under test. Single instance.

Vatt vatt 0 DC 1

* Inverting amp: (+) at GND, (-) = nminus virtual ground; out = nvatt
Eop  nvatt 0 0 nminus 1e6
Rin  vatt  nminus 10k          ; R_inv_in (inverter input)
Rf   nvatt nminus 10k          ; R_inv_f (inverter feedback) — must match R_inv_in

.control
  op
  let g_inv = v(nvatt)          ; DERIVED -(R_inv_f/R_inv_in)*1 = -(10k/10k) = -1.0
  print g_inv
.endc
.end
