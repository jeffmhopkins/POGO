* POGO block-4 VCA — HIGH-3 Ec+ trim authority (change 0020; runner-ready 0022)
* The old series-rheostat trim into the high-Z Ec+ port can't set an offset; the §HIGH-3
* voltage-injection trim (buffered V_CTRL via R_ec + trim wiper via R_inj across a ±ref) does.
* THAT2180 Ec+ ≈ +6.1 mV/dB; model the port as 10M to GND + 50nA bias.
* Mirrored on the 6 block-6 DRIVE VCAs.

.param Rport=10meg
.param Ibias=50n

* --- (a) BUGGY series rheostat (500ohm) from V_CTRL=0 to Ec+ ---
Vctrl_a vca 0 DC 0
Rrheo vca ecpa 500
Rpa ecpa 0 {Rport}
Iba ecpa 0 DC {Ibias}

* --- (b) FIXED injection: buffered V_CTRL via R_ec; trim wiper (±1.195V = the corrected REF_P/N, change 0025) via R_inj ---
Vbuf vcbuf 0 DC 0          ; V_CTRL=0 (unity target)
Rec vcbuf ecpb 10k
Vwp twp 0 DC 1.195         ; trim wiper at +ref end
Rinjp twp ecpb 1meg
Rpb ecpb 0 {Rport}
Ibb ecpb 0 DC {Ibias}

Vbuf2 vcbuf2 0 DC 0
Rec2 vcbuf2 ecpc 10k
Vwn twn 0 DC -1.195        ; trim wiper at -ref end
Rinjn twn ecpc 1meg
Rpc ecpc 0 {Rport}
Ibc ecpc 0 DC {Ibias}

.control
  op
  let rheo_dB = v(ecpa)/0.0061      ; authority of the BUGGY series rheostat (≈0)
  let inj_hi_dB = v(ecpb)/0.0061    ; injection trim, wiper +end
  let inj_lo_dB = v(ecpc)/0.0061    ; injection trim, wiper -end
  print rheo_dB inj_hi_dB inj_lo_dB
.endc
.end
