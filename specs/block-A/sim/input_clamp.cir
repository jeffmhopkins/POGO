* POGO block-A — input buffer: unity follower + BAT54S clamp + R1 clamp-current
* Plugin (InputBuffer.hpp / Pogo.cpp): buffered input, ±11V clamp. Hardware: OPA1612 unity
* follower; 100Ω series (R1) + BAT54S dual Schottky to the ±12V rails. The clamp LEVEL
* (~±12.3V = rail+Vf) is set by the BAT54S part [NV]; R1's real job is to set the CLAMP
* CURRENT I=(Vin-Vclamp)/R1 (it protects the diode) — that current is the R1-load-bearing,
* netlist-bound fact. (clamp_hi stays documentary [NV]; clamp_i is the falsifiable check.)
.param Rprot=100          ; = R1 (100Ω series protection); netlist-bound below

* --- (1) unity follower, in-band (Vin=3V); R1 into open buffer output is value-independent ---
Vsig sa 0 DC 3
Ebuf bufa 0 sa 0 1        ; ideal unity follower
Rsa bufa outa {Rprot}     ; series R into open output (unity unaffected — topology fact)

* --- (2) over-voltage: Vin=+17V through R1 into the BAT54S clamp held at +12.3 ([NV] level).
*     The clamp node is pinned by the diode (level [NV]); R1 carries I=(17-12.3)/R1.
Vov ov 0 DC 17
Rov ov tip {Rprot}        ; R1 — carries the clamp current (load-bearing: i depends on Rprot)
Bcl tip 0 V = (V(ov) > 12.3) ? 12.3 : ((V(ov) < -12.3) ? -12.3 : V(ov))  ; clamp node (level [NV])

.control
  op
  let unity = v(bufa)/3.0        ; unity follower gain = 1 (topology, no bind)
  let clamp_hi = v(tip)          ; protected-node level ~+12.3V ([NV], BAT54S Vf + rail)
  let clamp_i = abs(i(Vov))      ; clamp current through R1 = (17-12.3)/Rprot; R1-load-bearing
  print unity clamp_hi clamp_i
.endc
.end
